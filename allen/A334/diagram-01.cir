* Two-stage differential-output op amp with identical Miller compensation networks Cc-Rz from d1 to vout+ (M6) and from d2 to vout- (M7)
VDD vdd 0 {V_DD}
VSS vss 0 {V_SS}
M3 d1 vbp vdd vdd PMOS W={W3} L={L}
M4 d2 vbp vdd vdd PMOS W={W3} L={L}
M1 d1 vinp tail vss NMOS W={W1} L={L}
M2 d2 vinn tail vss NMOS W={W1} L={L}
M5 tail vbn vss vss NMOS W={W5} L={L}
M8 s6 vbp vdd vdd PMOS W={W8} L={L}
M6 voutp d1 s6 vdd PMOS W={W6} L={L}
M7 voutn d2 s6 vdd PMOS W={W6} L={L}
M9 voutp vbn vss vss NMOS W={W9} L={L}
M10 voutn vbn vss vss NMOS W={W9} L={L}
Rz1 d1 x1 {R_z}
Cc1 x1 voutp {C_c}
Rz2 d2 x2 {R_z}
Cc2 x2 voutn {C_c}
CL1 voutp 0 {C_L}
CL2 voutn 0 {C_L}
.end

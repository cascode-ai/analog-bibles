* Small-signal model of the common-gate stage M1 (gate at ac ground, source driven by Vin) with the cascode load replaced by R_L
Vin in 0 AC 1
G1 out in 0 in {gm1}
RO1 out in {rO1}
RL out 0 {R_L}
.end

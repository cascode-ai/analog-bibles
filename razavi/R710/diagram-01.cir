* Equivalent capacitor network per unit area: terminal A (metal 4 + metal 2), terminal B (metal 3), parasitic of the bottom plate (metal 2) to the substrate
C43 A B {C_43}
C32 B A {C_32}
CP A 0 {C_P}
.end

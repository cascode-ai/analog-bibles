* Small-signal noise model: M2 (gate at node S) injects -gm2*v_S + I_n2 into the output, in parallel with R_D and its noise; M1 with its noise connects out to S; R_S with its Norton noise goes from S to ground
Vin in 0 {v_in}
RD out 0 {R_D}
InD 0 out {I_nD}
G2 out 0 S 0 {gm2}
In2 0 out {I_n2}
G1 out S in S {gm1}
In1 out S {I_n1}
RS S 0 {R_S}
InS S 0 {I_nS}
.end

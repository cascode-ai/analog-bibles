* Low-frequency noise model of the distributed gate for n = 3: each segment R_G/3 carries a series noise voltage V_j, and each unit transistor is a transconductance gm/3 controlled by its own gate tap g_k
VG G 0 0
R1 G a1 {R_G/3}
V1 g1 a1 {V_1}
R2 g1 a2 {R_G/3}
V2 g2 a2 {V_2}
R3 g2 a3 {R_G/3}
V3 g3 a3 {V_3}
G1 D 0 g1 0 {gm/3}
G2 D 0 g2 0 {gm/3}
G3 D 0 g3 0 {gm/3}
VD D 0 0
.end

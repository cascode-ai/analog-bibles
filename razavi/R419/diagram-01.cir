* Small-signal model of the positive-feedback loop: M1 into the diode M3 (1/gm3) shunted by C1, mirrored by M2 back into the input node X
IX 0 X AC 1
G1 D 0 X 0 {gm1}
RM3 D 0 {1/gm3}
C1 D 0 {C1}
G2 0 X 0 D {gm2}
.end

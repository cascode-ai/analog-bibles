* Left input alone: M1 as a common-source stage degenerated by R_S, the resistance seen looking into the source of M2
Vin in 0 {v_in}
M1 X in P 0 nmos
RD1 vdd X {R_D}
RS P 0 {R_S}
VDD vdd 0 {V_DD}
.end

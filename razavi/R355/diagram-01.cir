* Small-signal noise model of the differential pair with current-mirror load, output shorted to ac ground (the current in VO is the short-circuit output current); the diode M3 is a resistance 1/gm3 and the ideal tail source is open
Vin1 g1 0 {v_in1}
Vin2 g2 0 {v_in2}
R3 X 0 {1/gm3}
In3 0 X {I_n3}
G4 0 out 0 X {gm4}
In4 0 out {I_n4}
G1 X P g1 P {gm1}
In1 X P {I_n1}
G2 out P g2 P {gm2}
In2 out P {I_n2}
VO out 0 0
.end

* Small-signal circuit for a common-mode input: M1 and M2 as gm sources, the diode-connected loads M3 and M4 as resistances 1/gm3 and 1/gm4 to ac ground (VDD), the tail transistor as its output resistance R_SS
Vcm cm 0 {v_CM}
G1 X P cm P {g_m1}
G2 Y P cm P {g_m2}
R3 X 0 {1/g_m3}
R4 Y 0 {1/g_m4}
RSS P 0 {R_SS}
.end

* Small-signal noise model of the degenerated common-source stage: channel noise I_n1 across M1, series noise voltage V_nS in the source resistor, Norton noise I_nD across the load
Vin in 0 {v_in}
G1 out S in S {gm}
In1 out S {I_n1}
VnS S x {V_nS}
RS x 0 {R_S}
RD out 0 {R_D}
InD 0 out {I_nD}
.end

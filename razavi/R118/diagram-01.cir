* Small-signal model: CS device M2 with the current source M1 reduced to rO1 at its source S and the current-source load M3 reduced to rO3 at the output
Vin in 0 AC 1
RO3 out 0 {rO3}
G2 out S in S {gm2}
RO2 out S {rO2}
RO1 S 0 {rO1}
.end

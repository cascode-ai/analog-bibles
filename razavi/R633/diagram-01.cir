* Low-frequency small-signal model: capacitors open, each inductor reduced to its series resistance RS, loop broken at the gate of M1
Vt g1 0 {vt}
G1 X 0 g1 0 {gm1}
RS1 X 0 {R_S}
RP1 X 0 {R_P}
G2 Y 0 X 0 {gm2}
RS2 Y 0 {R_S}
RP2 Y 0 {R_P}
.end

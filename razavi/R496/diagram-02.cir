* High-frequency reduced model after compensation (r_O3 neglected): node A is a capacitive divider, so M1 behaves almost like a diode at node B
RBP B 0 {1/G_Bp}
CBP B 0 {C_Bp}
CGD2 B Y {C_GD2}
G2 Y 0 B 0 {gm2}
RO2 Y 0 {r_O2}
CREP Y 0 {C_GS3+C_GD3}
.end

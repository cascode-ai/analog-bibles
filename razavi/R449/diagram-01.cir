* Small-signal model of the closed loop: op amp as a transconductance gm1 driving R_out, with the C1-C2 divider feeding node X back
Vin in 0 AC 1
G1 0 out in X {gm1}
Rout out 0 {R_out}
C1 out X {C1}
C2 X 0 {C2}
.end

* Small-signal model of the capacitive-feedback inverter (lambda = 0): C1 from the input to the gate node A, C2 from A to out, both transistors as g_m*V_A from out to ac ground
V1 in 0 AC 1
C1 in A {C_1}
C2 A out {C_2}
G1 out 0 A 0 {g_m1}
G2 out 0 A 0 {g_m2}
.end

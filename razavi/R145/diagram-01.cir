* Measuring Gm of the source follower: output shorted to ac ground through a zero-volt source Vsc (drain at ac ground, bulk at ground, ideal bias current source open)
Vin in 0 AC 1
G1 0 out in out {gm}
Gmb 0 out 0 out {gmb}
RO 0 out {rO}
RL out 0 {R_L}
Vsc out 0 0
.end

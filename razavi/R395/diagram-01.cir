* Small-signal model: CS stage M1 (N to out) with the source follower M2 returning a current to node N; current sources ideal (open)
Vin in 0 {V_in}
RS in n {R_S}
G2 0 n out n {gm2}
G1 out 0 n 0 {gm1}
.end

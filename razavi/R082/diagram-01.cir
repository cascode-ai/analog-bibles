* Small-signal model of the CS stage with diode-connected load when M1 is 50 mV into the triode region
Vin in 0 {v_in}
* M1 (triode): transconductance gm1 = beta1*VDS1 in parallel with the channel resistance rds1
G1 out 0 in 0 {gm1}
Rds1 out 0 {r_ds1}
* M2 (saturated, diode-connected): gate and drain at AC ground, source at out, v_gs2 = -v_out
G2 0 out 0 out {gm2}
.end

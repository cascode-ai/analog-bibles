* Impedance looking into the source of M2 (node X): gate at ac ground, drain loaded by Z_L = R_L in parallel with C_L
VX X 0 AC 1
G2 out X 0 X {g_m2}
Gmb2 out X 0 X {g_mb2}
RO2 out X {r_O2}
RL out 0 {R_L}
CL out 0 {C_L}
.end

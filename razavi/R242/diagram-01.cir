* Common-mode equivalent circuit: M1 and M2 merged into one device (2gm1, 2gmb1, rO1/2), M3 and M4 merged into a diode-connected load (1/(2gm3) in parallel with rO3/2) at the shared node F = out, tail M5 replaced by R_SS = rO5
Vcm cm 0 {v_CM}
G12 out P cm P {2*g_m1}
Gb12 out P 0 P {2*g_mb1}
RO12 out P {r_O1/2}
R34 out 0 {1/(2*g_m3)}
RO34 out 0 {r_O3/2}
RSS P 0 {r_O5}
.end

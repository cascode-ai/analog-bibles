* Low-frequency model of the OTA in the capacitive feedback loop: transconductance gm1 into r_O2 || r_O4
Vin in 0 {V_in}
G1 0 out in x {gm1}
Rout out 0 {r_O2||r_O4}
C1 out x {C_1}
C2 x 0 {C_2}
.end

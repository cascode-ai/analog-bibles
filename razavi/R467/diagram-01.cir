* Small-signal model of the left output: M5 driven by X, active pull-up M7 mirroring M11, whose current is set by M9 driven by Y (vY = -vX)
VX X 0 AC 1
EY Y 0 X 0 -1
G5 out1 0 X 0 {gm5}
RO5 out1 0 {r_O5}
G9 A 0 Y 0 {gm9}
RO9 A 0 {r_O9}
G11 A 0 A 0 {gm11}
RO11 A 0 {r_O11}
G7 0 out1 0 A {gm7}
RO7 out1 0 {r_O7}
.end

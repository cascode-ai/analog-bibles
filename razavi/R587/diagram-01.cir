* Small-signal model in the amplification phase: the op amp is a transconductance Gm controlled by V_X, with output resistance R0 and no load capacitance
Vin in 0 {V_in}
C1 in x {C_1}
Cin x 0 {C_in}
C2 x out {C_2}
G1 out 0 x 0 {G_m}
R0 out 0 {R_0}

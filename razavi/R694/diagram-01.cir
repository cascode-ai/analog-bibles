* Small-signal model of the NMOS cascode current source (M1 bottom, M2 cascode) with a test source V_X and a parasitic leakage path R_leak at the output
VX out 0 {V_X}
R2 out X {r_O2}
G1 out X 0 X {gm2}
G2 out X 0 X {gmb2}
R1 X 0 {r_O1}
Rleak out 0 {R_leak}
.end

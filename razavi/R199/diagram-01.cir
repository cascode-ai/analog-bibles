* Differential half circuit: M1 as a VCCS with rO1, current-source load rO3, and half of R1 to the virtual ground
Vin in 0 AC {vd/2}
G1 X 0 in 0 {gm1}
RO1 X 0 {rO1}
RO3 X 0 {rO3}
RH X 0 {R_1/2}
.end

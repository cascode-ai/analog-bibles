* Equivalent capacitor network per unit area: terminal A (metal 4 + metal 2 + poly), terminal B (metal 3 + metal 1), parasitic of the bottom plate (poly) to the substrate
C43 A B {C_43}
C32 B A {C_32}
C21 A B {C_21}
C1P B A {C_1P}
CP A 0 {C_P}
.end

* Model used for V_Y/V_in with load: ideal source at X, amplifier as -A*V_X behind R_out, C_F from X to Y, C_L from Y to ground
Vin x 0 AC {V_in}
E1 n1 0 x 0 {-A}
Rout n1 y {R_out}
CF x y {C_F}
CL y 0 {C_L}
.end

* Small-signal model of the comparison common-source stage: R_S in series with the gate, source grounded, C_GD bridging gate and drain
V1 in 0 AC 1
RS in G {R_S}
CGS G 0 {C_GS}
CGD G out {C_GD}
G1 out 0 G 0 {g_m}
RD out 0 {R_D}
CDB out 0 {C_DB}
.end

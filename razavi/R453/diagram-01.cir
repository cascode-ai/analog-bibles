* Differential half circuit of the folded cascode with the gate-referred flicker-noise sources of M1, M7, M9 (folding node F, bottom node B)
Vin in 0 AC 1
Vn1 in g1 {V_n1}
G1 F 0 g1 0 {gm1}
RO1 F 0 {r_O1}
Vn7 g7 0 {V_n7}
G7 0 F 0 g7 {gm7}
RO7 F 0 {r_O7}
G5 F out F 0 {gm5}
RO5 F out {r_O5}
G3 out B 0 B {gm3}
RO3 out B {r_O3}
Vn9 g9 0 {V_n9}
G9 B 0 g9 0 {gm9}
RO9 B 0 {r_O9}
.end

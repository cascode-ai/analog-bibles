* Differential half circuit at balance: node P is a virtual ground, VDD and Vb2 are AC grounds
Vin in 0 AC {vin_d/2}
M1 X in 0 0 nmos
M3 X 0 s3 s3 pmos
R1 s3 0 {R_1}
.end

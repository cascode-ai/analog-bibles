* Small-signal model of one side: slow path (M1 into X, then M5) and fast path (M2' injecting directly into out1); node h carries vin/2
Vh h 0 AC 1
G1 X 0 h 0 {gm1}
RO1 X 0 {r_O1}
RO3 X 0 {r_O3}
G5 out1 0 X 0 {gm5}
G2p 0 out1 h 0 {gm1p}
RO5 out1 0 {r_O5}
RO7 out1 0 {r_O7}
RO1p out1 0 {r_O1p}
.end

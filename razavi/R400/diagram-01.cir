* Small-signal model: inverter M1-M2 reduced to Gm = gm1 + gm2 and R = rO1 || rO2, with C1 and C2
Vin in 0 AC 1
C1 in G {C1}
C2 G out {C2}
G1 out 0 G 0 {Gm}
R1 out 0 {R}
.end

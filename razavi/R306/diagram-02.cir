* High-frequency small-signal equivalent: C1, C2 shorted, M2 diode-connected (gate at out), gate of M3 at ac ground, R1 and R2 loading the output
V1 in 0 AC 1
G1 X 0 in 0 {g_m1}
RO1 X 0 {r_O1}
G2 out X out X {g_m2}
RO2 out X {r_O2}
RO3 out 0 {r_O3}
R1 out 0 {R_1}
R2 out 0 {R_2}
.end

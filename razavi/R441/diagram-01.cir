* Small-signal model of the regulated-cascode stage with the channel-noise current of every transistor
Vin in 0 AC 1
G1 X 0 in 0 {gm1}
RO1 X 0 {r_O1}
In1 X 0 {I_n1}
G2 out X G X {gm2}
Gmb2 out X 0 X {gmb2}
RO2 out X {r_O2}
In2 out X {I_n2}
G3 G 0 X 0 {gm3}
RO3 G 0 {r_O3}
In3 G 0 {I_n3}
ROP1 G 0 {r_OP1}
InP1 0 G {I_nP1}
ROP2 out 0 {r_OP2}
InP2 0 out {I_nP2}
.end

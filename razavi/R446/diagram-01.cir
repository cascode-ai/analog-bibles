* Error amplifier with PMOS input pair (MA, MB) and NMOS current-mirror load (MC, MD); its output E drives the gates of M3 and M4
VDD vdd 0 {V_DD}
Vcm cm 0 {V_out,CM}
Vref ref 0 {V_REF}
MT tail vbp vdd vdd pmos
MA n1 cm tail vdd pmos
MB E ref tail vdd pmos
MC n1 n1 0 0 nmos
MD E n1 0 0 nmos
M3 d3 E 0 0 nmos
M4 d4 E 0 0 nmos
.end

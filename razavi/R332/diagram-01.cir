* Small-signal model of the CMOS inverter amplifier with the flicker noise of each transistor as a voltage V_n1, V_n2 in series with its gate
Vin in 0 {v_in}
Vn1 g1 in {V_n1}
Vn2 g2 in {V_n2}
G1 out 0 g1 0 {gm1}
G2 out 0 g2 0 {gm2}
RO1 out 0 {r_O1}
RO2 out 0 {r_O2}
.end

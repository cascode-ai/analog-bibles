* Small-signal noise model of the cascode with R_F across M2: all branches between out and X (M2, its noise, R_F, its noise) together carry exactly the current that the ideal current source M1 sinks from X
Vin in 0 {v_in}
RD out 0 {R_D}
InD 0 out {I_nD}
G2 out X 0 X {gm2}
In2 out X {I_n2}
RF out X {R_F}
InF out X {I_nF}
G1 X 0 in 0 {gm1}
In1 X 0 {I_n1}
.end

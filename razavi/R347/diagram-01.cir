* Small-signal noise model: M2 (gate at out) injects -gm2*v_out + I_n2 into the input node, which is also loaded by R_G with its noise; M1 and R_D with their noise set the output
G1 out 0 in 0 {gm1}
In1 out 0 {I_n1}
RD out 0 {R_D}
InD 0 out {I_nD}
RG in 0 {R_G}
InG in 0 {I_nG}
G2 in 0 out 0 {gm2}
In2 0 in {I_n2}
.end

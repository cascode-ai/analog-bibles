* Small-signal model of the common-gate stage M1 with the C1-C2 feedback divider (lambda = 0, I1 ideal)
Vin in 0 AC 1
G1 out in P in {gm1}
G2 out in 0 in {gmb1}
C1 out P {C1}
C2 P 0 {C2}
.end

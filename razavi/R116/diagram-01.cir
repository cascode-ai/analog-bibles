* Small-signal model: M2 with the diode-connected M3 replaced by R_D = (1/gm3)||rO3 and the diode-connected M1 replaced by R_S = (1/gm1)||rO1
Vin in 0 AC 1
RD out 0 {R_D}
G2 out S in S {gm2}
RO2 out S {rO2}
RS S 0 {R_S}
.end

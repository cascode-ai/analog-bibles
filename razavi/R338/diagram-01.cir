* Small-signal noise model of the folded cascode: M1 sinks gm1*v_in + I_n1 from node X, R_S (with its noise) ties X to ac ground, and the PMOS M2 passes gm2*v_X + I_n2 from X into the output loaded by R_D
Vin in 0 {v_in}
G1 X 0 in 0 {gm1}
In1 X 0 {I_n1}
RS X 0 {R_S}
InS 0 X {I_nS}
G2 X out X 0 {gm2}
In2 X out {I_n2}
RD out 0 {R_D}
InD 0 out {I_nD}
.end

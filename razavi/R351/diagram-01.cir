* Small-signal noise model: the follower M1 drives out (bias source I_1 open for ac); M2 (gate at out, source grounded) sinks gm2*v_out + I_n2 from the input node
G1 0 out in out {gm1}
In1 0 out {I_n1}
G2 in 0 out 0 {gm2}
In2 in 0 {I_n2}
.end

* Model: step source at X, amplifier as the controlled source -A*V_X behind R_out, and C_F from X to Y
Vstep x 0 {Delta_V}
E1 n1 0 x 0 {-A}
Rout n1 y {R_out}
CF x y {C_F}
.end

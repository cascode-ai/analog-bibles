* Common-mode equivalent of the op amp: M1 and M2 in parallel degenerated by R_SS, loaded by M3 and M4 acting as diode loads
Vcm in 0 AC 1
G12 A P in P {2*gm1}
RO12 A P {r_O1/2}
RSS P 0 {R_SS}
G34 A 0 A 0 {2*gm3}
RO34 A 0 {r_O3/2}
.end

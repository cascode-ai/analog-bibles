* Small-signal model for a common-mode input with mismatched transconductances gm1 and gm2: both see vgs = vcm - vP, the tail resistance RSS carries both currents, and the loads are equal
VCM cm 0 {v_cm}
G1 X P cm P {g_m1}
G2 Y P cm P {g_m2}
RD1 X 0 {R_D}
RD2 Y 0 {R_D}
RSS P 0 {R_SS}
.end

* Small-signal model seen at the output terminal (source of the NMOS): gate and drain at ac ground (VDD), bulk at ground, test voltage vx at node out
Vx out 0 {v_x}
G1 0 out 0 out {gm}
G2 0 out 0 out {gmb}
RO 0 out {r_O}
.end

* Small-signal circuit for the resistance at node X with both inputs grounded: M2 degenerated by the source of M1 (R_S = 1/gm1 || rO1), in parallel with rO3
It 0 X AC 1
G2 X P 0 P {gm2}
RO2 X P {r_O2}
RS P 0 {R_S}
RO3 X 0 {r_O3}
.end

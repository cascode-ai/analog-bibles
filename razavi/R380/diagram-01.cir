* Equivalent circuit seen by V_n1 with the input open: CS stage degenerated by r_O2 and loaded by r_O3
Vn1 g 0 {V_n1}
G1 out x g x {gm1}
Gmb1 out x 0 x {gmb1}
RO1 out x {r_O1}
RO2 x 0 {r_O2}
RO3 out 0 {r_O3}
.end

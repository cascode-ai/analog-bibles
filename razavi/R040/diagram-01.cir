* Distributed-gate model (n = 3) in the f_T test: gate-resistance ladder, each section with C/n to ac ground and gm/n, drains summed through VD
Iin 0 in {I_in}
R1 in g1 {R_G/n}
R2 g1 g2 {R_G/n}
R3 g2 g3 {R_G/n}
C1 g1 0 {C/n}
C2 g2 0 {C/n}
C3 g3 0 {C/n}
G1 d 0 g1 0 {gm/n}
G2 d 0 g2 0 {gm/n}
G3 d 0 g3 0 {gm/n}
VD d 0 0
.end

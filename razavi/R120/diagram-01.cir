* Small-signal model: M1 drives node X, cascode M2 (gate at ac ground) connects X to the output, and PMOS M3 (gate driven by X, source at ac ground) loads the output
Vin in 0 AC 1
G1 X 0 in 0 {gm1}
RO1 X 0 {rO1}
G2 out X 0 X {gm2}
RO2 out X {rO2}
G3 out 0 X 0 {gm3}
RO3 out 0 {rO3}
.end

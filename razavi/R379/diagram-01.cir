* Small-signal model of Fig. 2 with Z_L removed (drain open): V_n and Z_1 in series with the gate, C_GS, Z_S, g_mb and r_O
Vn a 0 {V_n}
R1 a g {Z_1}
CGS g s {C_GS}
RS s 0 {Z_S}
Gm d s g s {gm}
Gmb d s 0 s {gmb}
RO d s {r_O}
.end

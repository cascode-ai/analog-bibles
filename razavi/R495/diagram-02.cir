* High-frequency reduced model (r_O3 neglected): node A acts as a capacitive divider, so node B sees the conductance G_B' and the capacitance C_B'
RBP B 0 {1/G_Bp}
CBP B 0 {C_Bp}
CGD2 B Y {C_GD2}
G2 Y 0 B 0 {gm2}
RO2 Y 0 {r_O2}
CREP Y 0 {C_GS3+C_GD3}
.end

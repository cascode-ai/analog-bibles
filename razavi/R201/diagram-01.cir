* Small-signal half circuit: M1 (VCCS gm1, rO1) at node B, M3 with gate at B (VCCS gm3*vB out of A, rO3) at output A, R1 between A and B
Vin in 0 AC {vd/2}
G1 B 0 in 0 {gm1}
RO1 B 0 {rO1}
R1 A B {R_1}
G3 A 0 B 0 {gm3}
RO3 A 0 {rO3}
.end

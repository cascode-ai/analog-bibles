* Small-signal model of the loop broken at the gate of M1: test source vt drives the gate, the inverter output is the returned signal
Vt g1 0 {vt}
G1 E 0 g1 0 {gm}
R1 E 0 {R_D}
C1 E 0 {C_L}
G2 F 0 E 0 {gm}
R2 F 0 {R_D}
C2 F 0 {C_L}
E1 out 0 F 0 -1
.end

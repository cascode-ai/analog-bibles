* Half-circuit small-signal model of the Miller-compensated op amp (C_C from X to Vout1; M1 and M5 replaced by transconductances)
Vin in 0 AC 1
G1 X 0 in 0 {gm1}
RX X 0 {R_X}
CC X out {C_C}
G5 out 0 X 0 {gm5}
RL out 0 {R_L}
CL out 0 {C_L}
.end

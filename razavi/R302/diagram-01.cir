* Small-signal model (lambda = gamma = 0, ideal current sources open, V_b1 and V_b2 at ac ground): M1 from drain out to source X, PMOS M2 from drain X to source out
V1 in 0 AC 1
RS in X {R_S}
G1 out X 0 X {g_m1}
G2 X out 0 out {g_m2}
.end

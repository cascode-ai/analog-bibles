* One side of the op amp with the capacitances that set the three poles (node X, mirror node A, output out1; vY = -vX)
Vin in 0 AC 1
G1 X 0 in 0 {gm1/2}
RX X 0 {R_X}
CX X 0 {C_X}
EY Y 0 X 0 -1
CGD5 X out1 {C_GD5}
G5 out1 0 X 0 {gm5}
G9 A 0 Y 0 {gm9}
G11 A 0 A 0 {gm11}
CA A 0 {C_A}
G7 0 out1 0 A {gm7}
CGD7 A out1 {C_GD7}
RO5 out1 0 {r_O5}
RO7 out1 0 {r_O7}
CL out1 0 {C_L}
.end

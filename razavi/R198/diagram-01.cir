* Small-signal model for the output resistance of M3 degenerated by R1 (gate and bulk at AC ground, test source at the drain X)
Vx X 0 AC {vx}
G3 X s3 0 s3 {gm3}
Gb3 X s3 0 s3 {gmb3}
RO3 X s3 {rO3}
R1 s3 0 {R_1}
.end

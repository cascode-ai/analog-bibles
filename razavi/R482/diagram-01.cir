* Small-signal model of the transimpedance amplifier with the loop broken at the gate of M2 (test voltage Vt applied, Iin set to zero)
Vt t 0 AC 1
G2 0 Y t Y {gm2}
CY Y 0 {C_Y}
RF Y A {R_F}
CA A 0 {C_A}
G1 X 0 A 0 {gm1}
RD X 0 {R_D}
CX X 0 {C_X}
.end

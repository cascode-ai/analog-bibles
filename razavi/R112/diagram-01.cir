* Small-signal model: M1 (common source) and M2 (source follower) driven by the same input, VDD at ac ground
Vin in 0 AC 1
G1 out 0 in 0 {gm1}
RO1 out 0 {rO1}
G2 0 out in out {gm2}
RO2 0 out {rO2}
.end

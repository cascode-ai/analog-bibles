* Half-circuit small-signal model with the nulling resistor Rz in series with C_C (node M between them)
Vin in 0 AC 1
G1 X 0 in 0 {gm1}
RX X 0 {R_X}
Rz X M {R_z}
CC M out {C_C}
G5 out 0 X 0 {gm5}
RL out 0 {R_L}
CL out 0 {C_L}
.end

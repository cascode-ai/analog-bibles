* Differential pair with PMOS current-source loads (gates at the fixed bias V_b), series input resistances R_S and output capacitances C_L
VDD vdd 0 {V_DD}
Vb b 0 {V_b}
Vin1 in1 0 {V_in1}
Vin2 in2 0 {V_in2}
RS1 in1 g1 {R_S}
RS2 in2 g2 {R_S}
M1 out1 g1 P 0 nmos
M2 out2 g2 P 0 nmos
M3 out1 b vdd vdd pmos
M4 out2 b vdd vdd pmos
ISS P 0 {I_SS}
CL1 out1 0 {C_L}
CL2 out2 0 {C_L}
.end

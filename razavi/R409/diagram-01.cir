* Small-signal model for the exact nodal analysis (lambda of all devices and body effect of M1 included)
Vin in 0 AC 1
G1 X S in S {gm1}
Gmb1 X S 0 S {gmb1}
RO1 X S {r_O1}
RO2 X 0 {r_O2}
G3 0 out 0 X {gm3}
RO3 out 0 {r_O3}
RS1 S 0 3k
RF S out 3k
RD2 out 0 3k
.end

* Eight bond wires in one row, all drawn from package to chip: L1-L4 carry the supply (vdd to vddc), L5-L8 the ground return (0 to gndc); adjacent wires are coupled with k = M/L = 0.5
VDD vdd 0 {V_DD}
L1 vdd vddc {L}
L2 vdd vddc {L}
L3 vdd vddc {L}
L4 vdd vddc {L}
L5 0 gndc {L}
L6 0 gndc {L}
L7 0 gndc {L}
L8 0 gndc {L}
K12 L1 L2 {k}
K23 L2 L3 {k}
K34 L3 L4 {k}
K45 L4 L5 {k}
K56 L5 L6 {k}
K67 L6 L7 {k}
K78 L7 L8 {k}
I1 vddc gndc {I_DD}
.end

* Small-signal model of the cascode with C1 from X to out (for lambda = 0 remove rO1, rO2, rO3; M3 is then an open circuit)
V1 in 0 AC 1
G1 X 0 in 0 {g_m1}
RO1 X 0 {r_O1}
G2 out X 0 X {g_m2}
RO2 out X {r_O2}
RO3 out 0 {r_O3}
C1 X out {C_1}
.end

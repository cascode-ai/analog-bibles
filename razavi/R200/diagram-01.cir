* Differential half circuit: node N (PMOS gates, midpoint of R1-R2) is AC ground, so M3 reduces to rO3 and R1 goes from X to ground
Vin in 0 AC {vd/2}
G1 X 0 in 0 {gm1}
RO1 X 0 {rO1}
RO3 X 0 {rO3}
R1 X 0 {R_1}
.end

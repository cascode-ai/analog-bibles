* Small-signal model of the cascode for any region of M1 (gm1 and output resistance rds1 = 1/gds1) with M2 conducting as a common-gate device (gate at ac ground)
Vin in 0 AC 1
G1 X 0 in 0 {gm1}
RDS1 X 0 {rds1}
G2 out X 0 X {gm2}
RD out 0 {R_D}
.end

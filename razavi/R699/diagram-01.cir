* Equivalent circuit of node X: L_b to the supply (AC ground), M1 modelled as its gate capacitance C in series with the channel ESR R_S, and the digital circuit as a current source I_DD
VDD vdd 0 {V_DD}
L1 vdd X {L_b}
RS X Y {R_S}
C1 Y 0 {C}
I1 X 0 {I_DD}
.end

* Small-signal half circuit of the two-stage op amp (CS stage M1 with load M3, then CS stage M5 with load M7)
Vin in 0 AC 1
G1 X 0 in 0 {gm1}
RO1 X 0 {r_O1}
RO3 X 0 {r_O3}
G5 out1 0 X 0 {gm5}
RO5 out1 0 {r_O5}
RO7 out1 0 {r_O7}
.end

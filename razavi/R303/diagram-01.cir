* Small-signal model (lambda = gamma = 0, ideal current sources open, V_b2 at ac ground): common-gate M1 from drain out to source X, follower M2 as g_m2*(v_out - v_X) from VDD into X
V1 in 0 AC 1
RS in X {R_S}
G1 out X 0 X {g_m1}
G2 0 X out X {g_m2}
.end
